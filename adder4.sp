.include "cmos_cells.sp"
.subckt ADDER4 A0 A1 A2 A3 B0 B1 B2 B3 CIN S0 S1 S2 S3 COUT VDD VSS
XFA0 A0 B0 CIN S0 C1 VDD VSS FULLADDER
XFA1 A1 B1 C1 S1 C2 VDD VSS FULLADDER
XFA2 A2 B2 C2 S2 C3 VDD VSS FULLADDER
XFA3 A3 B3 C3 S3 COUT VDD VSS FULLADDER
.ends ADDER4
